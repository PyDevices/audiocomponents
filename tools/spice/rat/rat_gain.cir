* rat_gain.cir -- Rat two-leg feedback network + GBW-limited op-amp, AC.
*
* Values from Distortion.md S1. GBW defaults to 0.32 MHz, the assumption
* that reproduces S1's "no more than 30dB" at 10 kHz (dossier F2 / Q4).
.include models.lib
.param pos=1
.param gbw=3.2e5
Vcc vcc 0 dc 9
Vee vee 0 dc 0
Vin in 0 dc 4.5 ac 1
XU1 in inn out vcc vee opgbw
Rf  out inn {100k*pos + 1}
C4  out inn 100p
R4  inn n4 47
C5  n4  0  2.2u
R5  inn n5 560
C6  n5  0  4.7u

.control
set wr_vecnames
set wr_singlescale
ac dec 50 20 20k
wrdata out/gain_ac_posmax.csv vdb(out) vp(out)
quit
.endc
.end
