* rat_clip.cir -- ProCo Rat diodes-to-ground clipper (R6 1K, D1/D2 to ground)
*
* Topology from Distortion.md S1. The op-amp and Filter are omitted: this
* deck is the memoryless pair the waveshaper table is derived from.
* Driven from an ideal source through R6; the pair sits to ground.
*
* Simplifications: no C7 coupling, no R6 current-limit vs an op-amp source
* impedance other than the 1K itself, matched 1N4148, 0 V bias (the digital
* graph has no 4.5 V rail).
.include models.lib
.param amp=1.0
Vin in 0 sin(0 {amp} 1k)
R6  in out 1k
XD1 out 0 1N4148
XD2 0 out 1N4148

.control
set wr_vecnames
set wr_singlescale
set fe = ".csv"
foreach a 0.35 1.0 3.5
  set fn = "out/clip_tran_amp$a"
  alterparam amp = $a
  reset
  tran 1u 20m 0 1u
  linearize v(out) v(in)
  wrdata $fn$fe v(out) v(in)
end
quit
.endc
.end
